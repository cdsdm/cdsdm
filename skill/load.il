; load.il
;

load( strcat( cdsdm_git->skill "/cdsdm_cancel.il" ) )
load( strcat( cdsdm_git->skill "/cdsdm_cdslib.il" ) )
load( strcat( cdsdm_git->skill "/cdsdm_cdslib_backup.il" ) )
load( strcat( cdsdm_git->skill "/cdsdm_checkin.il" ) )
load( strcat( cdsdm_git->skill "/cdsdm_checkout.il" ) )
load( strcat( cdsdm_git->skill "/cdsdm_check_add.il" ) )
load( strcat( cdsdm_git->skill "/cdsdm_check_branch.il" ) )
load( strcat( cdsdm_git->skill "/cdsdm_check_remote.il" ) )
load( strcat( cdsdm_git->skill "/cdsdm_clone.il" ) )
load( strcat( cdsdm_git->skill "/cdsdm_config.il" ) )
load( strcat( cdsdm_git->skill "/cdsdm_gc.il" ) )
load( strcat( cdsdm_git->skill "/cdsdm_gitk.il" ) )
load( strcat( cdsdm_git->skill "/cdsdm_init.il" ) )
load( strcat( cdsdm_git->skill "/cdsdm_list_add.il" ) )
load( strcat( cdsdm_git->skill "/cdsdm_lmgr_cb.il" ) )
load( strcat( cdsdm_git->skill "/cdsdm_lmgr_popup.il" ) )
load( strcat( cdsdm_git->skill "/cdsdm_lmgr_proc.il" ) )
load( strcat( cdsdm_git->skill "/cdsdm_log.il" ) )
load( strcat( cdsdm_git->skill "/cdsdm_permission.il" ) )
load( strcat( cdsdm_git->skill "/cdsdm_pull.il" ) )
load( strcat( cdsdm_git->skill "/cdsdm_push.il" ) )
load( strcat( cdsdm_git->skill "/cdsdm_remote.il" ) )
load( strcat( cdsdm_git->skill "/cdsdm_trigger.il" ) )
load( strcat( cdsdm_git->skill "/cdsdm_xterm.il" ) )

;
;
